* FF, high supply, cold
.lib /foss/pdks/sky130A/libs.tech/ngspice/sky130.lib.spice ff
.param VDD=1.98 VCM=0.99 VBN=0.63
.temp -40
.include eeg_fd_ota_highgain_pvt_body.inc
